.SUBCKT C0805X102K1RACAUTO
*Temp = 25?C, Bias = 0VDC, Center Frequency = 10000 Hz
*KEMET Model RLC Cerm
R1 3 4 263.81768798828125
R2 2 5 25.600000381469727
R3 1 6 99999997952
L1 1 2 2.000000026702864E-11
L2 2 3 3.800000050735441E-10
C1 4 6 9.636583753191985E-10
C2 5 6 3.25E-12
*ENDS
